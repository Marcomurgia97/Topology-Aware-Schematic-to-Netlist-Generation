L1 N_ANT 0 VALUE
C1 N_ANT 0 VALUE
D1 N_ANT N_D1_C2 DIODE
C2 N_D1_C2 N_Q1_B VALUE
R1 VCC N_Q1_B VALUE
Q1 N_Q1_C N_Q1_B 0 NPN
R2 N_Q1_C VCC VCC VALUE
LT1_P VCC N_Q1_C VALUE
LT1_S N_Q2_B N_Q2_BIAS VALUE
K1 LT1_P LT1_S 1.0
Q2 N_Q2_C N_Q2_B 0 NPN
R3 VCC N_Q2_BIAS VALUE
C3 N_Q2_BIAS 0 VALUE
R4 N_Q2_C N_HP VALUE
R_HP N_HP VCC VALUE
